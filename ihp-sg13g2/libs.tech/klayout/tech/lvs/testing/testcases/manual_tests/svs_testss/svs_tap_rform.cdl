*==========================================================================
* Copyright 2026 IHP PDK Authors
*
* Licensed under the Apache License, Version 2.0 (the "License");
* you may not use this file except in compliance with the License.
* You may obtain a copy of the License at
*
*    https://www.apache.org/licenses/LICENSE-2.0
*
* Unless required by applicable law or agreed to in writing, software
* distributed under the License is distributed on an "AS IS" BASIS,
* WITHOUT WARRANTIES OR CONDITIONS OF ANY KIND, either express or implied.
* See the License for the specific language governing permissions and
* limitations under the License.
* SPDX-License-Identifier: Apache-2.0
*==========================================================================
************************************************************************
* Manual SVS testcase: reference, ptap1/ntap1 taps in R form
************************************************************************

.SUBCKT svs_tap A B C VDD VSS
R1 A VSS ptap1 A=608.4f P=3.12u
R2 B VDD ntap1 A=624.0f P=3.16u
R3 C VDD ntap1 A=640.0f P=3.20u
.ENDS
